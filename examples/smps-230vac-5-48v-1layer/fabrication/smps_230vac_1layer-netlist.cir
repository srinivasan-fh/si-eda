* SMPS 230 VAC to 5-48 V 5 A (CC/CV)
* Generated by SiEDA
* J1 (TERMINAL-3P-5.08, 230VAC) has no SPICE model
* F1 (FUSE-5X20-HOLDER, T5A 250VAC) has no SPICE model
* RV1 (S10K275, S10K275) has no SPICE model
* CX1 (X2-100N-275VAC, X2-100N-275VAC) has no SPICE model
* LF1 (CMC-2X10MH-6A, 2x10mH) has no SPICE model
* CX2 (X2-100N-275VAC, X2-100N-275VAC) has no SPICE model
CY2 L_F PE 2.2n
CY3 N_F PE 2.2n
* BR1 (GBU4M, GBU4M) has no SPICE model
RT1 RECT_RAW RECT 5R
CIN1 RECT PGND 1u
* U1 (L6563, L6563) has no SPICE model
* LPFC (L-PFC-400U-ZCD, 400uH) has no SPICE model
* Q1 (C3M0065100K, C3M0065100K) has no SPICE model
* DPFC (DIODE-TO220-2, SiC 650V 10A) has no SPICE model
* CB1 (CAP-SNAPIN-30MM, 220u 450V) has no SPICE model
R1 VBULK JW_NET87 1.5M
R2 JW_NET87 PFC_INV 1.5M
R3 PFC_INV PGND 19.1k
C1 N_1 PFC_INV 680n
R4 RECT JW_NET40 1.5M
R5 JW_NET40 JW_NET81 1.5M
R6 JW_NET81 PGND 22k
C2 JW_NET81 PGND 10n
C3 JW_NET68 PGND 1u
R7 JW_NET68 PGND 1M
R8 JW_NET71 PGND 33k
R9 VBULK N_4 1.5M
R10 N_4 JW_NET72 1.5M
R15 JW_NET72 PGND 24k
R16 VCC_P JW_NET74 100k
R17 JW_NET74 PGND 10k
R11 JW_NET45 PFC_ZCD 68k
R12 PFC_GATE JW_NET39 10
R13 JW_NET84 PGND 0.1
R14 JW_NET84 PFC_ISNS 100
C4 VCC_P PGND 100n
* U2 (UC3843, UC3843) has no SPICE model
* Q2 (C3M0065100K, C3M0065100K) has no SPICE model
* T1 (T-FLYBACK-ETD44, ETD44) has no SPICE model
* DOUT (DIODE-TO220-2, 200V 20A ultrafast) has no SPICE model
DSN FLY_SW SNUB DSIEDA
R20 VBULK SNUB 100k
C5 VBULK SNUB 2.2n
R18 N_5 PGND 0.15
R19 FLY_OUT N_6 10
R21 N_5 FLY_ISNS 1k
C6 FLY_ISNS PGND 470p
R22 FLY_VREF JW_NET2 10k
C7 JW_NET2 PGND 2.2n
C8 FLY_VREF PGND 100n
DAUX AUX_W VAUX DSIEDA
C9 VAUX PGND 47u
* U6 (LM7812, LM7812) has no SPICE model
C10 VCC_P PGND 10u
R23 VBULK VAUX 330k
* C11 (CAP-RADIAL-12.5MM, 1000u 63V) has no SPICE model
* C12 (CAP-RADIAL-12.5MM, 1000u 63V) has no SPICE model
* U3 (PC817, PC817) has no SPICE model
* U4 (TL431AIDBZR, TL431AIDBZR) has no SPICE model
R24 V52 OPTO_A 1k
R25 OPTO_A FB_K 1k
R26 V52 FB_REF 51k
R27 FB_REF SGND 2.55k
R28 FB_K N_7 10k
C13 N_7 FB_REF 100n
DB BIAS_W VBIAS_S DSIEDA
C14 VBIAS_S SGND 47u
* U7 (LM7812, LM7812) has no SPICE model
C15 VCC_S SGND 10u
* CY1 (CAP-Y1-DISC-10MM, 2.2n Y1) has no SPICE model
* U5 (UC3843, UC3843) has no SPICE model
* U8 (IR2104, IR2104) has no SPICE model
* Q3 (BSC040N10NS5, BSC040N10NS5) has no SPICE model
* Q4 (BSC040N10NS5, BSC040N10NS5) has no SPICE model
* LB (L-POWER-33U-10A, 33uH) has no SPICE model
R29 N_8 HS_G 10
R30 JW_NET22 LS_G 10
R31 VCC_S BUCK_EN 10k
DBST VCC_S BOOT DSIEDA
C16 BOOT SW 220n
C17 VCC_S SGND 1u
* C18 (CAP-RADIAL-12.5MM, 1000u 63V) has no SPICE model
* C19 (CAP-RADIAL-12.5MM, 1000u 63V) has no SPICE model
C20 VOUT SGND 100n
* J2 (TERMINAL-2P-5.08, 5-48V 5A) has no SPICE model
R32 I_RTN SGND 0.01
* NT1 (NetTie-2, NetTie-2) has no SPICE model
* NT2 (NetTie-2, NetTie-2) has no SPICE model
C21 VREF5 SGND 100n
R33 VREF5 JW_NET41 10k
C22 JW_NET41 SGND 1n
R34 JW_NET43 SGND 1k
* U9 (LM358, LM358) has no SPICE model
DCV COMP2 CV_OUT DSIEDA
DCC COMP2 CC_OUT DSIEDA
R35 VOUT JW_NET42 100k
R36 JW_NET42 SGND 10k
C23 CV_OUT JW_NET42 10n
C24 CC_OUT N_9 10n
R37 INA_OUT N_9 1k
* U10 (INA181A2IDBVR, INA181A2IDBVR) has no SPICE model
C25 VREF5 SGND 100n
* J3 (PinHeader_1x04_P2.54mm, VSET/ISET) has no SPICE model
R38 VSET SGND 100k
R39 ISET SGND 100k
C26 VCC_S SGND 100n
C27 VCC_S SGND 100n
C28 VCC_S SGND 100n
DPWR N_10 SGND DLED
R40 VCC_S N_10 4.7k
* MH1 (MH-M3-PE, MH-M3-PE) has no SPICE model
* JW1 (WIRE-LINK-42.75, Wire link) has no SPICE model
* JW2 (WIRE-LINK-11.25, Wire link) has no SPICE model
* JW3 (WIRE-JUMPER-13.31x9.98, Wire link) has no SPICE model
* JW4 (WIRE-LINK-34.25, Wire link) has no SPICE model
* JW5 (WIRE-LINK-8.50x6.75, Wire link) has no SPICE model
* JW6 (WIRE-JUMPER-16.26x55.45, Wire link) has no SPICE model
* JW7 (WIRE-LINK-9.75x9.75, Wire link) has no SPICE model
* JW8 (WIRE-LINK-26.25, Wire link) has no SPICE model
* JW9 (WIRE-LINK-34.75x1.00, Wire link) has no SPICE model
* JW10 (WIRE-LINK-1.50x3.00, Wire link) has no SPICE model
* JW11 (WIRE-LINK-2.50x2.50, Wire link) has no SPICE model
* JW12 (WIRE-LINK-3.00, Wire link) has no SPICE model
* JW13 (WIRE-LINK-8.07x16.97, Wire link) has no SPICE model
* JW14 (WIRE-LINK-4.00x4.00, Wire link) has no SPICE model
* JW15 (WIRE-LINK-25.00, Wire link) has no SPICE model
* JW16 (WIRE-LINK-3.75x5.00, Wire link) has no SPICE model
* JW17 (WIRE-LINK-14.75x21.50, Wire link) has no SPICE model
* JW18 (WIRE-JUMPER-20.77x18.82, Wire link) has no SPICE model
* JW19 (WIRE-LINK-7.00x4.50, Wire link) has no SPICE model
* JW20 (WIRE-LINK-0.75x18.75, Wire link) has no SPICE model
* JW21 (WIRE-JUMPER-16.25x40.50, Wire link) has no SPICE model
* JW22 (WIRE-LINK-6.00x6.00, Wire link) has no SPICE model
* JW23 (WIRE-LINK-16.25x2.00, Wire link) has no SPICE model
* JW24 (WIRE-LINK-1.75x2.75, Wire link) has no SPICE model
* JW25 (WIRE-LINK-20.75x15.75, Wire link) has no SPICE model
* JW26 (WIRE-LINK-9.00, Wire link) has no SPICE model
* JW27 (WIRE-LINK-5.75x5.25, Wire link) has no SPICE model
* JW28 (WIRE-LINK-1.62x10.03, Wire link) has no SPICE model
* JW29 (WIRE-LINK-6.50x16.50, Wire link) has no SPICE model
* JW30 (WIRE-LINK-1.75x18.00, Wire link) has no SPICE model
* JW31 (WIRE-LINK-25.75x25.75, Wire link) has no SPICE model
* JW32 (WIRE-LINK-11.54x2.35, Wire link) has no SPICE model
* JW33 (WIRE-LINK-8.00x13.75, Wire link) has no SPICE model
* JW34 (WIRE-LINK-11.75, Wire link) has no SPICE model
* JW35 (WIRE-LINK-1.00x4.00, Wire link) has no SPICE model
* JW36 (WIRE-LINK-11.25x11.25, Wire link) has no SPICE model
* JW37 (WIRE-LINK-6.75x2.25, Wire link) has no SPICE model
* JW38 (WIRE-LINK-5.00x5.00, Wire link) has no SPICE model
* JW39 (WIRE-LINK-5.25x5.25, Wire link) has no SPICE model
* JW40 (WIRE-LINK-4.75x6.00, Wire link) has no SPICE model
* JW41 (WIRE-LINK-5.25, Wire link) has no SPICE model
* JW42 (WIRE-LINK-13.25, Wire link) has no SPICE model
* JW43 (WIRE-LINK-27.75, Wire link) has no SPICE model
* JW44 (WIRE-LINK-22.75, Wire link) has no SPICE model
* JW45 (WIRE-LINK-2.25x13.75, Wire link) has no SPICE model
* JW46 (WIRE-LINK-4.00x8.75, Wire link) has no SPICE model
* JW47 (WIRE-LINK-3.00x0.50, Wire link) has no SPICE model
* JW48 (WIRE-LINK-4.25x0.25, Wire link) has no SPICE model
* JW49 (WIRE-LINK-2.75x8.50, Wire link) has no SPICE model
* JW50 (WIRE-LINK-11.50, Wire link) has no SPICE model
* JW51 (WIRE-LINK-8.25x16.25, Wire link) has no SPICE model
* JW52 (WIRE-LINK-1.00x16.75, Wire link) has no SPICE model
* JW53 (WIRE-JUMPER-10.74x18.28, Wire link) has no SPICE model
* JW54 (WIRE-LINK-3.75x3.75, Wire link) has no SPICE model
* JW55 (WIRE-LINK-1.25x36.25, Wire link) has no SPICE model
* JW56 (WIRE-LINK-11.84x3.66, Wire link) has no SPICE model
* JW57 (WIRE-LINK-4.75x34.25, Wire link) has no SPICE model
* JW58 (WIRE-LINK-2.25x5.05, Wire link) has no SPICE model
* JW59 (WIRE-LINK-3.25x3.25, Wire link) has no SPICE model
* JW60 (WIRE-LINK-12.25x12.25, Wire link) has no SPICE model
* JW61 (WIRE-LINK-8.50x8.50, Wire link) has no SPICE model
* JW62 (WIRE-LINK-21.75, Wire link) has no SPICE model
* JW63 (WIRE-LINK-4.50, Wire link) has no SPICE model
* JW64 (WIRE-LINK-4.75x4.75, Wire link) has no SPICE model
* JW65 (WIRE-LINK-2.25x2.25, Wire link) has no SPICE model
* JW66 (WIRE-LINK-7.00x2.75, Wire link) has no SPICE model
* JW67 (WIRE-LINK-7.00, Wire link) has no SPICE model
* JW68 (WIRE-LINK-9.25x9.25, Wire link) has no SPICE model
* JW69 (WIRE-LINK-8.25, Wire link) has no SPICE model
* JW70 (WIRE-LINK-0.75x25.25, Wire link) has no SPICE model
* JW71 (WIRE-LINK-8.25x20.75, Wire link) has no SPICE model
* JW72 (WIRE-LINK-12.75x0.25, Wire link) has no SPICE model
* JW73 (WIRE-LINK-7.56x12.17, Wire link) has no SPICE model
* JW74 (WIRE-LINK-1.75x8.50, Wire link) has no SPICE model
* JW75 (WIRE-LINK-21.66x5.03, Wire link) has no SPICE model
* JW76 (WIRE-LINK-4.25x6.00, Wire link) has no SPICE model
* JW77 (WIRE-LINK-0.76x8.02, Wire link) has no SPICE model
* JW78 (WIRE-LINK-16.75x31.50, Wire link) has no SPICE model
* JW79 (WIRE-LINK-1.00x9.25, Wire link) has no SPICE model
* JW80 (WIRE-LINK-31.00, Wire link) has no SPICE model
* JW81 (WIRE-LINK-8.25, Wire link) has no SPICE model
* JW82 (WIRE-LINK-2.09x13.77, Wire link) has no SPICE model
* JW83 (WIRE-LINK-19.02x35.55, Wire link) has no SPICE model
* JW84 (WIRE-LINK-20.75x1.75, Wire link) has no SPICE model
* JW85 (WIRE-LINK-10.73x6.49, Wire link) has no SPICE model
* JW86 (WIRE-LINK-19.25x0.25, Wire link) has no SPICE model
* JW87 (WIRE-LINK-18.75x11.75, Wire link) has no SPICE model
* JW88 (WIRE-LINK-20.00x8.50, Wire link) has no SPICE model
.model DLED D(Is=1e-18 N=2)
.model DSIEDA D(Is=2.52n N=1.752)
.op
.end
