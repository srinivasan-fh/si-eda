* SMPS 230 VAC to 5-48 V 5 A (CC/CV)
* Generated by SiEDA
* J1 (TERMINAL-3P-5.08, 230VAC) has no SPICE model
* F1 (FUSE-5X20-HOLDER, T5A 250VAC) has no SPICE model
* RV1 (S10K275, S10K275) has no SPICE model
* CX1 (X2-100N-275VAC, X2-100N-275VAC) has no SPICE model
* LF1 (CMC-2X10MH-6A, 2x10mH) has no SPICE model
* CX2 (X2-100N-275VAC, X2-100N-275VAC) has no SPICE model
CY2 L_F PE 2.2n
CY3 N_F PE 2.2n
* BR1 (GBU4M, GBU4M) has no SPICE model
RT1 RECT_RAW RECT 5R
CIN1 RECT PGND 1u
* U1 (L6563, L6563) has no SPICE model
* LPFC (L-PFC-400U-ZCD, 400uH) has no SPICE model
* Q1 (C3M0065100K, C3M0065100K) has no SPICE model
* DPFC (DIODE-TO220-2, SiC 650V 10A) has no SPICE model
* CB1 (CAP-SNAPIN-30MM, 220u 450V) has no SPICE model
R1 VBULK N_12 1.5M
R2 N_12 PFC_INV 1.5M
R3 PFC_INV PGND 19.1k
C1 N_1 PFC_INV 680n
R4 RECT N_13 1.5M
R5 N_13 N_2 1.5M
R6 N_2 PGND 22k
C2 N_2 PGND 10n
C3 N_3 PGND 1u
R7 N_3 PGND 1M
R8 N_4 PGND 33k
R9 VBULK N_14 1.5M
R10 N_14 N_5 1.5M
R15 N_5 PGND 24k
R16 VCC_P N_8 100k
R17 N_8 PGND 10k
R11 N_9 PFC_ZCD 68k
R12 PFC_GATE N_11 10
R13 N_10 PGND 0.1
R14 N_10 PFC_ISNS 100
C4 VCC_P PGND 100n
* U2 (UC3843, UC3843) has no SPICE model
* Q2 (C3M0065100K, C3M0065100K) has no SPICE model
* T1 (T-FLYBACK-ETD44, ETD44) has no SPICE model
* DOUT (DIODE-TO220-2, 200V 20A ultrafast) has no SPICE model
DSN FLY_SW SNUB DSIEDA
R20 VBULK SNUB 100k
C5 VBULK SNUB 2.2n
R18 N_16 PGND 0.15
R19 FLY_OUT N_17 10
R21 N_16 FLY_ISNS 1k
C6 FLY_ISNS PGND 470p
R22 FLY_VREF N_15 10k
C7 N_15 PGND 2.2n
C8 FLY_VREF PGND 100n
DAUX AUX_W VAUX DSIEDA
C9 VAUX PGND 47u
* U6 (LM7812, LM7812) has no SPICE model
C10 VCC_P PGND 10u
R23 VBULK VAUX 330k
* C11 (CAP-RADIAL-12.5MM, 1000u 63V) has no SPICE model
* C12 (CAP-RADIAL-12.5MM, 1000u 63V) has no SPICE model
* U3 (PC817, PC817) has no SPICE model
* U4 (TL431AIDBZR, TL431AIDBZR) has no SPICE model
R24 V52 OPTO_A 1k
R25 OPTO_A FB_K 1k
R26 V52 FB_REF 51k
R27 FB_REF SGND 2.55k
R28 FB_K N_18 10k
C13 N_18 FB_REF 100n
DB BIAS_W VBIAS_S DSIEDA
C14 VBIAS_S SGND 47u
* U7 (LM7812, LM7812) has no SPICE model
C15 VCC_S SGND 10u
* CY1 (CAP-Y1-DISC-10MM, 2.2n Y1) has no SPICE model
* U5 (UC3843, UC3843) has no SPICE model
* U8 (IR2104, IR2104) has no SPICE model
* Q3 (BSC040N10NS5, BSC040N10NS5) has no SPICE model
* Q4 (BSC040N10NS5, BSC040N10NS5) has no SPICE model
* LB (L-POWER-33U-10A, 33uH) has no SPICE model
R29 N_22 HS_G 10
R30 N_21 LS_G 10
R31 VCC_S BUCK_EN 10k
DBST VCC_S BOOT DSIEDA
C16 BOOT SW 220n
C17 VCC_S SGND 1u
* C18 (CAP-RADIAL-12.5MM, 1000u 63V) has no SPICE model
* C19 (CAP-RADIAL-12.5MM, 1000u 63V) has no SPICE model
C20 VOUT SGND 100n
* J2 (TERMINAL-2P-5.08, 5-48V 5A) has no SPICE model
R32 I_RTN SGND 0.01
* NT1 (NetTie-2, NetTie-2) has no SPICE model
* NT2 (NetTie-2, NetTie-2) has no SPICE model
C21 VREF5 SGND 100n
R33 VREF5 N_20 10k
C22 N_20 SGND 1n
R34 N_19 SGND 1k
* U9 (LM358, LM358) has no SPICE model
DCV COMP2 CV_OUT DSIEDA
DCC COMP2 CC_OUT DSIEDA
R35 VOUT N_23 100k
R36 N_23 SGND 10k
C23 CV_OUT N_23 10n
C24 CC_OUT N_24 10n
R37 INA_OUT N_24 1k
* U10 (INA181A2IDBVR, INA181A2IDBVR) has no SPICE model
C25 VREF5 SGND 100n
* J3 (PinHeader_1x04_P2.54mm, VSET/ISET) has no SPICE model
R38 VSET SGND 100k
R39 ISET SGND 100k
C26 VCC_S SGND 100n
C27 VCC_S SGND 100n
C28 VCC_S SGND 100n
DPWR N_25 SGND DLED
R40 VCC_S N_25 4.7k
* MH1 (MH-M3-PE, MH-M3-PE) has no SPICE model
.model DLED D(Is=1e-18 N=2)
.model DSIEDA D(Is=2.52n N=1.752)
.op
.end
